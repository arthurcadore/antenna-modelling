# Ansys Electronics Desktop project, version 2023.2
materials:
  vacuum: permittivity=1
  copper: permeability=0.999991 conductivity=58000000
  Isola FR408: permittivity=3.66 dielectric_loss_tangent=0.012

design HFSSDesign1 (HFSS, HFSS Terminal Network, model units mm)
geometry:
  gnd [copper] = box(corner=(0mm, 0mm, 0mm), size=(84.5mm, 339mm, 0.05mm))
  substract [Isola FR408] = box(corner=(0mm, 0mm, 0.05mm), size=(84.5mm, 339mm, 0.6mm))
  sq1 [copper] = box(corner=(33.3mm, 8.1mm, 0.65mm), size=(17.1mm, 17.1mm, 0.05mm))
  sq2 = box(corner=(33.3mm, 51mm, 0.65mm), size=(17.1mm, 17.1mm, 0.05mm))
  sq4 = box(corner=(33.3mm, 93.9mm, 0.65mm), size=(17.1mm, 17.1mm, 0.05mm))
  c1 = box(corner=(27.7mm, 15.9mm, 0.65mm), size=(5.6mm, 1.5mm, 0.05mm))
  c2 = box(corner=(27.7mm, 58.8mm, 0.65mm), size=(5.6mm, 1.5mm, 0.05mm))
  c3 = box(corner=(27.7mm, 15.9mm, 0.65mm), size=(1.5mm, 6.1mm, 0.05mm))
  c4 = box(corner=(27.7mm, 54.2mm, 0.65mm), size=(1.5mm, 6.1mm, 0.05mm))
  c5 = box(corner=(28.15mm, 22mm, 0.65mm), size=(0.6mm, 32.2mm, 0.05mm))
  c6 = box(corner=(18.65mm, 37.35mm, 0.65mm), size=(9.5mm, 1.5mm, 0.05mm))
  sq6 = box(corner=(33.3mm, 51mm, 0.65mm), size=(17.1mm, 17.1mm, 0.05mm))
  c7 = box(corner=(27.7mm, 15.9mm, 0.65mm), size=(5.6mm, 1.5mm, 0.05mm))
  c8 = box(corner=(27.7mm, 58.8mm, 0.65mm), size=(5.6mm, 1.5mm, 0.05mm))
  c9 = box(corner=(27.7mm, 15.9mm, 0.65mm), size=(1.5mm, 6.1mm, 0.05mm))
  c10 = box(corner=(27.7mm, 54.2mm, 0.65mm), size=(1.5mm, 6.1mm, 0.05mm))
  c11 = box(corner=(28.15mm, 22mm, 0.65mm), size=(0.6mm, 32.2mm, 0.05mm))
  [sq6, c7..c11].move(0mm, 85.8mm, 0mm)
  sq7 = box(corner=(33.3mm, 93.9mm, 0.65mm), size=(17.1mm, 17.1mm, 0.05mm))
  sq8 = box(corner=(33.3mm, 51mm, 0.65mm), size=(17.1mm, 17.1mm, 0.05mm))
  sq8.move(0mm, 85.8mm, 0mm)
  c13 = box(corner=(27.7mm, 15.9mm, 0.65mm), size=(5.6mm, 1.5mm, 0.05mm))
  c13.move(0mm, 85.8mm, 0mm)
  c14 = box(corner=(27.7mm, 58.8mm, 0.65mm), size=(5.6mm, 1.5mm, 0.05mm))
  c14.move(0mm, 85.8mm, 0mm)
  c15 = box(corner=(27.7mm, 15.9mm, 0.65mm), size=(1.5mm, 6.1mm, 0.05mm))
  c15.move(0mm, 85.8mm, 0mm)
  c16 = box(corner=(27.7mm, 54.2mm, 0.65mm), size=(1.5mm, 6.1mm, 0.05mm))
  c16.move(0mm, 85.8mm, 0mm)
  c17 = box(corner=(28.15mm, 22mm, 0.65mm), size=(0.6mm, 32.2mm, 0.05mm))
  c17.move(0mm, 85.8mm, 0mm)
  [sq7, sq8, c13..c17].move(0mm, 85.8mm, 0mm)
  sq9 = box(corner=(33.3mm, 93.9mm, 0.65mm), size=(17.1mm, 17.1mm, 0.05mm))
  sq9.move(0mm, 85.8mm, 0mm)
  sq10 = box(corner=(33.3mm, 51mm, 0.65mm), size=(17.1mm, 17.1mm, 0.05mm))
  sq10.move(0mm, 85.8mm, 0mm)
  sq10.move(0mm, 85.8mm, 0mm)
  c19 = box(corner=(27.7mm, 15.9mm, 0.65mm), size=(5.6mm, 1.5mm, 0.05mm))
  c19.move(0mm, 85.8mm, 0mm)
  c19.move(0mm, 85.8mm, 0mm)
  c20 = box(corner=(27.7mm, 58.8mm, 0.65mm), size=(5.6mm, 1.5mm, 0.05mm))
  c20.move(0mm, 85.8mm, 0mm)
  c20.move(0mm, 85.8mm, 0mm)
  c21 = box(corner=(27.7mm, 15.9mm, 0.65mm), size=(1.5mm, 6.1mm, 0.05mm))
  c21.move(0mm, 85.8mm, 0mm)
  c21.move(0mm, 85.8mm, 0mm)
  c22 = box(corner=(27.7mm, 54.2mm, 0.65mm), size=(1.5mm, 6.1mm, 0.05mm))
  c22.move(0mm, 85.8mm, 0mm)
  c22.move(0mm, 85.8mm, 0mm)
  c23 = box(corner=(28.15mm, 22mm, 0.65mm), size=(0.6mm, 32.2mm, 0.05mm))
  c23.move(0mm, 85.8mm, 0mm)
  c23.move(0mm, 85.8mm, 0mm)
  [sq9, sq10, c19..c23].move(0mm, 85.8mm, 0mm)
  c25 = box(corner=(41.1mm, 25.2mm, 0.65mm), size=(1.5mm, 5.9mm, 0.05mm))
  c26 = box(corner=(41.1mm, 45.1mm, 0.65mm), size=(1.5mm, 5.9mm, 0.05mm))
  c27 = box(corner=(41.1mm, 29.6mm, 0.65mm), size=(5.9mm, 1.5mm, 0.05mm))
  c28 = box(corner=(41.1mm, 45.1mm, 0.65mm), size=(5.9mm, 1.5mm, 0.05mm))
  c29 = box(corner=(47mm, 30.05mm, 0.65mm), size=(5.9mm, 0.6mm, 0.05mm))
  c30 = box(corner=(52.3mm, 30.05mm, 0.65mm), size=(0.6mm, 7.1mm, 0.05mm))
  c31 = box(corner=(49mm, 36.55mm, 0.65mm), size=(3.9mm, 0.6mm, 0.05mm))
  c32 = box(corner=(49mm, 36.55mm, 0.65mm), size=(0.6mm, 9.6mm, 0.05mm))
  c33 = box(corner=(47mm, 45.55mm, 0.65mm), size=(2.6mm, 0.6mm, 0.05mm))
  c34 = box(corner=(49.6mm, 45.1mm, 0.65mm), size=(7.4mm, 1.5mm, 0.05mm))
  c35 = box(corner=(41.1mm, 25.2mm, 0.65mm), size=(1.5mm, 5.9mm, 0.05mm))
  c36 = box(corner=(41.1mm, 45.1mm, 0.65mm), size=(1.5mm, 5.9mm, 0.05mm))
  c37 = box(corner=(41.1mm, 29.6mm, 0.65mm), size=(5.9mm, 1.5mm, 0.05mm))
  c38 = box(corner=(41.1mm, 45.1mm, 0.65mm), size=(5.9mm, 1.5mm, 0.05mm))
  c39 = box(corner=(47mm, 30.05mm, 0.65mm), size=(5.9mm, 0.6mm, 0.05mm))
  c40 = box(corner=(52.3mm, 30.05mm, 0.65mm), size=(0.6mm, 7.1mm, 0.05mm))
  c41 = box(corner=(49mm, 36.55mm, 0.65mm), size=(3.9mm, 0.6mm, 0.05mm))
  c42 = box(corner=(49mm, 36.55mm, 0.65mm), size=(0.6mm, 9.6mm, 0.05mm))
  c43 = box(corner=(47mm, 45.55mm, 0.65mm), size=(2.6mm, 0.6mm, 0.05mm))
  [c35..c43].move(0mm, 171.6mm, 0mm)
  c45 = box(corner=(41.1mm, 25.2mm, 0.65mm), size=(1.5mm, 5.9mm, 0.05mm))
  c46 = box(corner=(41.1mm, 45.1mm, 0.65mm), size=(1.5mm, 5.9mm, 0.05mm))
  c47 = box(corner=(41.1mm, 29.6mm, 0.65mm), size=(5.9mm, 1.5mm, 0.05mm))
  c48 = box(corner=(41.1mm, 45.1mm, 0.65mm), size=(5.9mm, 1.5mm, 0.05mm))
  c49 = box(corner=(47mm, 30.05mm, 0.65mm), size=(5.9mm, 0.6mm, 0.05mm))
  c50 = box(corner=(52.3mm, 30.05mm, 0.65mm), size=(0.6mm, 7.1mm, 0.05mm))
  c51 = box(corner=(49mm, 36.55mm, 0.65mm), size=(3.9mm, 0.6mm, 0.05mm))
  c52 = box(corner=(49mm, 36.55mm, 0.65mm), size=(0.6mm, 9.6mm, 0.05mm))
  c53 = box(corner=(47mm, 45.55mm, 0.65mm), size=(2.6mm, 0.6mm, 0.05mm))
  c54 = box(corner=(49.6mm, 45.1mm, 0.65mm), size=(7.4mm, 1.5mm, 0.05mm))
  [c45..c54].mirror(point=(41.1mm, 81mm, 0mm), normal=(0mm, 1mm, 0mm))
  c55 = box(corner=(41.1mm, 25.2mm, 0.65mm), size=(1.5mm, 5.9mm, 0.05mm))
  c55.move(0mm, 171.6mm, 0mm)
  c56 = box(corner=(41.1mm, 45.1mm, 0.65mm), size=(1.5mm, 5.9mm, 0.05mm))
  c56.move(0mm, 171.6mm, 0mm)
  c57 = box(corner=(41.1mm, 29.6mm, 0.65mm), size=(5.9mm, 1.5mm, 0.05mm))
  c57.move(0mm, 171.6mm, 0mm)
  c58 = box(corner=(41.1mm, 45.1mm, 0.65mm), size=(5.9mm, 1.5mm, 0.05mm))
  c58.move(0mm, 171.6mm, 0mm)
  c59 = box(corner=(47mm, 30.05mm, 0.65mm), size=(5.9mm, 0.6mm, 0.05mm))
  c59.move(0mm, 171.6mm, 0mm)
  c60 = box(corner=(52.3mm, 30.05mm, 0.65mm), size=(0.6mm, 7.1mm, 0.05mm))
  c60.move(0mm, 171.6mm, 0mm)
  c61 = box(corner=(49mm, 36.55mm, 0.65mm), size=(3.9mm, 0.6mm, 0.05mm))
  c61.move(0mm, 171.6mm, 0mm)
  c62 = box(corner=(49mm, 36.55mm, 0.65mm), size=(0.6mm, 9.6mm, 0.05mm))
  c62.move(0mm, 171.6mm, 0mm)
  c63 = box(corner=(47mm, 45.55mm, 0.65mm), size=(2.6mm, 0.6mm, 0.05mm))
  c63.move(0mm, 171.6mm, 0mm)
  [c55..c63].mirror(point=(41.1mm, 252.6mm, 0mm), normal=(0mm, 1mm, 0mm))
  c65 = box(corner=(18.65mm, 37.35mm, 0.65mm), size=(1.5mm, 3mm, 0.05mm))
  c66 = box(corner=(18.8mm, 40.35mm, 0.65mm), size=(1.2mm, 30.9mm, 0.05mm))
  c67 = box(corner=(19.1mm, 71.25mm, 0.65mm), size=(0.6mm, 19.5mm, 0.05mm))
  c6_1 = c6.duplicate_mirror(point=(0mm, 81mm, 0mm), normal=(0mm, 1mm, 0mm))
  c66_1 = c66.duplicate_mirror(point=(0mm, 81mm, 0mm), normal=(0mm, 1mm, 0mm))
  c65_1 = c65.duplicate_mirror(point=(0mm, 81mm, 0mm), normal=(0mm, 1mm, 0mm))
  c68 = box(corner=(18.65mm, 37.35mm, 0.65mm), size=(9.5mm, 1.5mm, 0.05mm))
  c6_2 = c68.duplicate_mirror(point=(0mm, 81mm, 0mm), normal=(0mm, 1mm, 0mm))
  c69 = box(corner=(18.65mm, 37.35mm, 0.65mm), size=(1.5mm, 3mm, 0.05mm))
  c65_2 = c69.duplicate_mirror(point=(0mm, 81mm, 0mm), normal=(0mm, 1mm, 0mm))
  c70 = box(corner=(18.8mm, 40.35mm, 0.65mm), size=(1.2mm, 30.9mm, 0.05mm))
  c66_2 = c70.duplicate_mirror(point=(0mm, 81mm, 0mm), normal=(0mm, 1mm, 0mm))
  c71 = box(corner=(19.1mm, 71.25mm, 0.65mm), size=(0.6mm, 19.5mm, 0.05mm))
  [c68..c71, c6_2, c66_2, c65_2].mirror(point=(0mm, 166.8mm, 0mm), normal=(0mm, 1mm, 0mm))
  c72 = box(corner=(9.6mm, 80.25mm, 0.65mm), size=(9.5mm, 1.5mm, 0.05mm))
  c73 = box(corner=(9.6mm, 80.25mm, 0.65mm), size=(1.5mm, 3mm, 0.05mm))
  c74 = box(corner=(9.75mm, 83.25mm, 0.65mm), size=(1.2mm, 73mm, 0.05mm))
  c75 = box(corner=(9.6mm, 80.25mm, 0.65mm), size=(9.5mm, 1.5mm, 0.05mm))
  c76 = box(corner=(9.6mm, 80.25mm, 0.65mm), size=(1.5mm, 3mm, 0.05mm))
  c77 = box(corner=(9.75mm, 83.25mm, 0.65mm), size=(1.2mm, 73mm, 0.05mm))
  [c75, c76, c77].mirror(point=(0mm, 166.8mm, 0mm), normal=(0mm, 1mm, 0mm))
  c78 = box(corner=(10.05mm, 156.25mm, 0.65mm), size=(0.6mm, 21.1mm, 0.05mm))
  c79 = box(corner=(1.05mm, 166.8mm, 0.65mm), size=(9mm, 2mm, 0.05mm))
  c80 = box(corner=(1.05mm, 78.3mm, 0.65mm), size=(2mm, 88.5mm, 0.05mm))
  c81 = box(corner=(55.5mm, 45.1mm, 0.65mm), size=(1.5mm, 4.5mm, 0.05mm))
  c82 = box(corner=(55.5mm, 45.1mm, 0.65mm), size=(1.5mm, 4.5mm, 0.05mm))
  c82.mirror(point=(41.1mm, 81mm, 0mm), normal=(0mm, 1mm, 0mm))
  c83 = box(corner=(55.65mm, 49.6mm, 0.65mm), size=(1.2mm, 11.5mm, 0.05mm))
  c83.mirror(point=(41.1mm, 81mm, 0mm), normal=(0mm, 1mm, 0mm))
  c84 = box(corner=(55.65mm, 49.6mm, 0.65mm), size=(1.2mm, 31.6mm, 0.05mm))
  c85 = box(corner=(55.95mm, 81.2mm, 0.65mm), size=(0.6mm, 19.7mm, 0.05mm))
  c86 = box(corner=(49.6mm, 45.1mm, 0.65mm), size=(7.4mm, 1.5mm, 0.05mm))
  c87 = box(corner=(49.6mm, 45.1mm, 0.65mm), size=(7.4mm, 1.5mm, 0.05mm))
  c87.mirror(point=(41.1mm, 81mm, 0mm), normal=(0mm, 1mm, 0mm))
  c88 = box(corner=(55.5mm, 45.1mm, 0.65mm), size=(1.5mm, 4.5mm, 0.05mm))
  c89 = box(corner=(55.5mm, 45.1mm, 0.65mm), size=(1.5mm, 4.5mm, 0.05mm))
  c89.mirror(point=(41.1mm, 81mm, 0mm), normal=(0mm, 1mm, 0mm))
  c90 = box(corner=(55.65mm, 49.6mm, 0.65mm), size=(1.2mm, 11.5mm, 0.05mm))
  c90.mirror(point=(41.1mm, 81mm, 0mm), normal=(0mm, 1mm, 0mm))
  c91 = box(corner=(55.65mm, 49.6mm, 0.65mm), size=(1.2mm, 31.6mm, 0.05mm))
  c92 = box(corner=(55.95mm, 81.2mm, 0.65mm), size=(0.6mm, 19.7mm, 0.05mm))
  [c86..c92].mirror(point=(0mm, 166.8mm, 0mm), normal=(0mm, 1mm, 0mm))
  c93 = box(corner=(56.55mm, 90.3mm, 0.65mm), size=(9.5mm, 1.5mm, 0.05mm))
  c94 = box(corner=(64.55mm, 90.3mm, 0.65mm), size=(1.5mm, 3mm, 0.05mm))
  c95 = box(corner=(56.55mm, 90.3mm, 0.65mm), size=(9.5mm, 1.5mm, 0.05mm))
  c96 = box(corner=(64.55mm, 90.3mm, 0.65mm), size=(1.5mm, 3mm, 0.05mm))
  [c95, c96].mirror(point=(0mm, 166.8mm, 0mm), normal=(0mm, 1mm, 0mm))
  c97 = box(corner=(64.7mm, 93.3mm, 0.65mm), size=(1.2mm, 52.3mm, 0.05mm))
  c98 = box(corner=(64.7mm, 93.3mm, 0.65mm), size=(1.2mm, 71.6mm, 0.05mm))
  c98.mirror(point=(0mm, 166.8mm, 0mm), normal=(0mm, 1mm, 0mm))
  c99 = box(corner=(65mm, 145.6mm, 0.65mm), size=(0.6mm, 23.1mm, 0.05mm))
  c100 = box(corner=(65.6mm, 156.15mm, 0.65mm), size=(8.5mm, 2mm, 0.05mm))
  c101 = box(corner=(72.1mm, 80.1mm, 0.65mm), size=(2mm, 78.05mm, 0.05mm))
  c102 = box(corner=(72.1mm, 80.1mm, 0.65mm), size=(6mm, 2mm, 0.05mm))
  Cylinder1 = cylinder(axis=Z, base_centre=(77.5mm, 81.1mm, 0.65mm), radius=0.6mm, height=-10mm)
  Cylinder2 = cylinder(axis=Z, base_centre=(2.05mm, 79.3mm, 0.65mm), radius=0.6mm, height=-10mm)
  Cylinder1_1 = Cylinder1.copy()
  gnd.subtract(Cylinder1_1)
  substract.subtract(Cylinder1)
  Cylinder2_1 = Cylinder2.copy()
  gnd.subtract(Cylinder2_1)
  substract.subtract(Cylinder2)
  Cylinder3 [copper] = cylinder(axis=Z, base_centre=(77.5mm, 81.1mm, 0.65mm), radius=0.5mm, height=-2.65mm)
  Cylinder4 [copper] = cylinder(axis=Z, base_centre=(2.05mm, 79.3mm, 0.65mm), radius=0.5mm, height=-2.65mm)
  Cylinder5 = cylinder(axis=Z, base_centre=(77.5mm, 81.1mm, 0mm), radius=2.4mm, height=-2mm)
  Cylinder5_ObjectFromFace1 [copper] = object_from(Cylinder5.face(side))
  Cylinder5.delete()
  Cylinder6 = cylinder(axis=Z, base_centre=(2.05mm, 79.3mm, 0mm), radius=2mm, height=-2mm)
  Cylinder6_ObjectFromFace1 = object_from(Cylinder6.face(side))
  Cylinder6.delete()
  Circle1 = circle(normal=Z, centre=(2.05mm, 79.3mm, -2mm), radius=2mm)
  Circle2 = circle(normal=Z, centre=(77.5mm, 81.1mm, -2mm), radius=2.4mm)
  sq1.unite(c3, c1, c5, c6, c65, c66, c4, c2, sq2, c26, c28, c33, c32, c31, c30, c29, c27, c25)
  sq1.unite(c34, c81, c84, c72, c67, c73, c74, c6_1, c65_1, c66_1, c9, c11, c7, sq4, c46, c48, c47, c45, sq6, c8, c10)
  sq1.unite(c102, c101, c93, c94, c97, c85, c83, c54, c82, c53, c52, c51, c50, c49)
  sq1.unite(c100, c99, c98, sq7, c35, c37, c39..c42, c87, c43, c38, c36, sq8, c14, c16, c17, c6_2, c15, c13, c89, c90, c95, c96, c92, c91, sq9, c56, c58, c63, c86, c88, c19, c21)
  sq1.unite(c66_2, c65_2, c75, c71, c70, c76, c79, c78, c77, c80, sq10, c20, c22, c23, c68, c69, c62, c61, c60, c57, c59, c55)
  Box1 [Isola FR408] = box(corner=(22.25mm, 0mm, 4.15mm), size=(40mm, 339mm, 0.6mm))
  Box2 [copper] = box(corner=(33.3mm, 8.1mm, 4.75mm), size=(17.1mm, 17.1mm, 0.05mm))
  Box3 [copper] = box(corner=(33.3mm, 8.1mm, 4.75mm), size=(17.1mm, 17.1mm, 0.05mm))
  Box3.move(0mm, 42.9mm, 0mm)
  Box4 [copper] = box(corner=(33.3mm, 8.1mm, 4.75mm), size=(17.1mm, 17.1mm, 0.05mm))
  Box4.move(0mm, 42.9mm, 0mm)
  Box4.move(0mm, 42.9mm, 0mm)
  Box5 [copper] = box(corner=(33.3mm, 8.1mm, 4.75mm), size=(17.1mm, 17.1mm, 0.05mm))
  Box5.move(0mm, 42.9mm, 0mm)
  Box5.move(0mm, 42.9mm, 0mm)
  Box5.move(0mm, 42.9mm, 0mm)
  Box6 [copper] = box(corner=(33.3mm, 8.1mm, 4.75mm), size=(17.1mm, 17.1mm, 0.05mm))
  Box6.move(0mm, 42.9mm, 0mm)
  Box6.move(0mm, 42.9mm, 0mm)
  Box6.move(0mm, 42.9mm, 0mm)
  Box6.move(0mm, 42.9mm, 0mm)
  Box7 [copper] = box(corner=(33.3mm, 8.1mm, 4.75mm), size=(17.1mm, 17.1mm, 0.05mm))
  Box7.move(0mm, 42.9mm, 0mm)
  Box7.move(0mm, 42.9mm, 0mm)
  Box7.move(0mm, 42.9mm, 0mm)
  Box7.move(0mm, 42.9mm, 0mm)
  Box7.move(0mm, 42.9mm, 0mm)
  Box8 [copper] = box(corner=(33.3mm, 8.1mm, 4.75mm), size=(17.1mm, 17.1mm, 0.05mm))
  Box8.move(0mm, 42.9mm, 0mm)
  Box8.move(0mm, 42.9mm, 0mm)
  Box8.move(0mm, 42.9mm, 0mm)
  Box8.move(0mm, 42.9mm, 0mm)
  Box8.move(0mm, 42.9mm, 0mm)
  Box8.move(0mm, 42.9mm, 0mm)
  Box9 [copper] = box(corner=(33.3mm, 8.1mm, 4.75mm), size=(17.1mm, 17.1mm, 0.05mm))
  Box9.move(0mm, 42.9mm, 0mm)
  Box9.move(0mm, 42.9mm, 0mm)
  Box9.move(0mm, 42.9mm, 0mm)
  Box9.move(0mm, 42.9mm, 0mm)
  Box9.move(0mm, 42.9mm, 0mm)
  Box9.move(0mm, 42.9mm, 0mm)
  Box9.move(0mm, 42.9mm, 0mm)
  Box10 [vacuum] = box(corner=(-10mm, -10mm, -2mm), size=(95.5mm, 395mm, 10mm))
boundaries and excitations:
  PerfE1: Perfect E Objects=Cylinder5_ObjectFromFace1
  PerfE2: Perfect E Objects=Cylinder6_ObjectFromFace1
  Rad1: Radiation Objects=Box10
  Circle2_T1: Terminal port=1 Faces=Cylinder3.face(-z end) TerminalResistance=50ohm
  Circle1_T1: Terminal port=2 Faces=Cylinder4.face(-z end) TerminalResistance=50ohm
  1: Wave Port Faces=Circle2.face WavePortType=Terminal NumModes=1
  2: Wave Port Faces=Circle1.face WavePortType=Terminal NumModes=1
  reference conductors: Cylinder6_ObjectFromFace1
setups:
  Setup1: HfssDriven Frequency=5GHz MaxDeltaS=0.02 MaximumPasses=5 MinimumPasses=1 MinimumConvergedPasses=1 PercentRefinement=30 BasisOrder=1 PortAccuracy=2 DrivenSolverType="Direct Solver"
    sweep Sweep: 4GHz to 6GHz, 401 points; Type=Interpolating InterpTolerance=0.5 InterpMaxSolns=250 PassivityErrorTolerance=0.0001
source amplitudes:
  1:1: 1V 0deg
  2:1: 0V 0deg
radiation setups:
  Infinite Sphere1: Infinite Sphere Theta=0deg..180deg step 2deg Phi=-180deg..180deg step 2deg
reports:
  Gain Plot 1: dB(GainTotal) vs Phi, Theta on Setup1 : LastAdaptive, Infinite Sphere1 [Freq=5GHz]
  Gain Plot 2: dB(GainTotal) vs Theta, Phi on Setup1 : LastAdaptive, Infinite Sphere1 [Freq=5GHz]
  Gain Plot 3: dB(GainTotal) vs Theta on Setup1 : LastAdaptive, Infinite Sphere1 [Phi=all Freq=5GHz]
  Gain Plot 4: dB(GainTotal) vs Phi, Theta on Setup1 : LastAdaptive, Infinite Sphere1 [Freq=5GHz]
  Antenna Params Plot 1: dB(PeakDirectivity) vs Freq on Setup1 : LastAdaptive
  Gain Plot 5: dB(GainTotal) vs Theta on Setup1 : LastAdaptive, Infinite Sphere1 [Phi=all Freq=5GHz]
  Gain Plot 6: dB(GainTotal) vs Phi, Theta on Setup1 : LastAdaptive, Infinite Sphere1 [Freq=5GHz]
  Gain Plot 7: dB(GainTotal) vs Phi, Theta on Setup1 : LastAdaptive, Infinite Sphere1 [Freq=5GHz]
